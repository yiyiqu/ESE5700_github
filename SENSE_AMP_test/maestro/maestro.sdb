ADE simulation setup
Run mode: Single Run, Sweeps and Corners
Tests:
  ESE5700_github:SENSE_AMP_test:1: ESE5700_github/SENSE_AMP_test/schematic, simulator spectre
