ADE simulation setup
Test ESE5700_github:SENSE_AMP_test:1: ESE5700_github/SENSE_AMP_test/schematic, simulator spectre
  Models: /lcars/software/linux/x86_64/ic-design/design_kits/gpdk045_v_6_0/gpdk045/../models/spectre/gpdk045.scs[mc]
  Temperature: 27
Run mode: Single Run, Sweeps and Corners
