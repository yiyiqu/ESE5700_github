ADE simulation setup
Run mode: Single Run, Sweeps and Corners
Tests:
  ESE5700_github:16x1SRAM_internal_test:1: ESE5700_github/16x1SRAM_internal_test/schematic, simulator spectre
